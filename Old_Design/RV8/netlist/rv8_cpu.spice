* SPICE netlist generated by Yosys 0.33 (git sha1 2584903a060)

.SUBCKT rv8_alu a.0 a.1 a.2 a.3 a.4 a.5 a.6 a.7 b.0 b.1 b.2 b.3 b.4 b.5 b.6 b.7 op.0 op.1 op.2 carry_in result.0 result.1 result.2 result.3 result.4 result.5 result.6 result.7 carry_out zero negative
X0 a.0 a.1 a.2 a.3 a.4 a.5 a.6 a.7 b.0 b.1 b.2 b.3 b.4 b.5 b.6 b.7 1.0 1.1 1.2 1.3 1.4 1.5 1.6 1.7 1.8 _add
X1 1.0 1.1 1.2 1.3 1.4 1.5 1.6 1.7 1.8 carry_in 2.0 2.1 2.2 2.3 2.4 2.5 2.6 2.7 2.8 _add
X2 a.0 a.1 a.2 a.3 a.4 a.5 a.6 a.7 b.0 b.1 b.2 b.3 b.4 b.5 b.6 b.7 3.0 3.1 3.2 3.3 3.4 3.5 3.6 3.7 _and
X3 tmp.0 tmp.1 tmp.2 tmp.3 tmp.4 tmp.5 tmp.6 tmp.7 zero _logic_not
X4 carry_in Vss Vss Vss Vss Vss Vss Vss Vss 4.0 4.1 4.2 4.3 4.4 4.5 4.6 4.7 4.8 _not
X5 a.0 a.1 a.2 a.3 a.4 a.5 a.6 a.7 b.0 b.1 b.2 b.3 b.4 b.5 b.6 b.7 5.0 5.1 5.2 5.3 5.4 5.5 5.6 5.7 _or
X6 _NC0 _NC1 _NC2 _NC3 _NC4 _NC5 _NC6 _NC7 _NC8 b.0 b.1 b.2 b.3 b.4 b.5 b.6 b.7 Vss Vss a.0 a.1 a.2 a.3 a.4 a.5 a.6 a.7 a.1 a.2 a.3 a.4 a.5 a.6 a.7 Vss a.0 6.0 6.1 6.2 6.3 6.4 6.5 6.6 6.7 Vss 5.0 5.1 5.2 5.3 5.4 5.5 5.6 5.7 Vss 3.0 3.1 3.2 3.3 3.4 3.5 3.6 3.7 Vss 7.0 7.1 7.2 7.3 7.4 7.5 7.6 7.7 7.8 2.0 2.1 2.2 2.3 2.4 2.5 2.6 2.7 2.8 8 9 10 11 12 13 14 15 tmp.0 tmp.1 tmp.2 tmp.3 tmp.4 tmp.5 tmp.6 tmp.7 tmp.8 _pmux
X7 op.0 op.1 op.2 Vdd Vdd Vdd 8 _eq
X8 op.0 op.1 op.2 Vss Vdd Vdd 9 _eq
X9 op.0 op.1 op.2 Vdd Vss Vdd 10 _eq
X10 op.0 op.1 op.2 Vss Vss Vdd 11 _eq
X11 op.0 op.1 op.2 Vdd Vdd Vss 12 _eq
X12 op.0 op.1 op.2 Vss Vdd Vss 13 _eq
X13 op.0 op.1 op.2 Vdd Vss Vss 14 _eq
X14 op.0 op.1 op.2 15 _logic_not
X15 a.0 a.1 a.2 a.3 a.4 a.5 a.6 a.7 b.0 b.1 b.2 b.3 b.4 b.5 b.6 b.7 16.0 16.1 16.2 16.3 16.4 16.5 16.6 16.7 16.8 _sub
X16 16.0 16.1 16.2 16.3 16.4 16.5 16.6 16.7 16.8 4.0 4.1 4.2 4.3 4.4 4.5 4.6 4.7 4.8 7.0 7.1 7.2 7.3 7.4 7.5 7.6 7.7 7.8 _sub
X17 a.0 a.1 a.2 a.3 a.4 a.5 a.6 a.7 b.0 b.1 b.2 b.3 b.4 b.5 b.6 b.7 6.0 6.1 6.2 6.3 6.4 6.5 6.6 6.7 _xor
V0 tmp.8 carry_out DC 0
V1 tmp.7 negative DC 0
V2 tmp.0 result.0 DC 0
V3 tmp.1 result.1 DC 0
V4 tmp.2 result.2 DC 0
V5 tmp.3 result.3 DC 0
V6 tmp.4 result.4 DC 0
V7 tmp.5 result.5 DC 0
V8 tmp.6 result.6 DC 0
V9 tmp.7 result.7 DC 0
.ENDS rv8_alu

.SUBCKT rv8_control clk rst_n opcode.0 opcode.1 opcode.2 opcode.3 opcode.4 opcode.5 opcode.6 opcode.7 operand.0 operand.1 operand.2 operand.3 operand.4 operand.5 operand.6 operand.7 flag_z flag_c flag_n flag_ie nmi_pending irq_pending reg_we mem_rd mem_wr alu_op.0 alu_op.1 alu_op.2 addr_src.0 addr_src.1 addr_src.2 pc_inc pc_load pc_branch flags_we ptr_inc ptr_dec sp_inc sp_dec ir_load0 ir_load1 halt_out ie_set ie_clr skip_set int_enter state_out.0 state_out.1 state_out.2
X0 rst_n clk 1 2 skip_flag _adffe
X1 3 4 2 _reduce_bool
X2 5 6 7 8 9 _reduce_or
X3 10 11 12 _reduce_or
X4 opcode.5 opcode.6 opcode.7 is_alu _logic_not
X5 opcode.5 opcode.6 opcode.7 Vdd Vss Vss is_imm _eq
X6 opcode.5 opcode.6 opcode.7 Vss Vdd Vss is_ldst _eq
X7 opcode.5 opcode.6 opcode.7 Vdd Vdd Vss is_branch _eq
X8 opcode.5 opcode.6 opcode.7 Vss Vss Vdd is_shift _eq
X9 opcode.5 opcode.6 opcode.7 Vdd Vss Vdd is_ptr _eq
X10 opcode.5 opcode.6 opcode.7 Vdd Vdd Vdd is_system _eq
X11 opcode.3 opcode.4 Vdd Vdd 13 _eq
X12 opcode.0 opcode.1 14 _logic_not
X13 opcode.0 opcode.1 Vdd Vss 15 _eq
X14 opcode.0 opcode.1 Vss Vdd 16 _eq
X15 opcode.0 opcode.1 opcode.2 opcode.3 opcode.4 opcode.5 opcode.6 opcode.7 Vss Vss Vdd Vdd Vss Vdd Vss Vss is_push _eq
X16 opcode.0 opcode.1 opcode.2 opcode.3 opcode.4 opcode.5 opcode.6 opcode.7 Vdd Vss Vdd Vdd Vss Vdd Vss Vss is_pop _eq
X17 opcode.0 opcode.1 opcode.2 opcode.3 opcode.4 opcode.5 opcode.6 opcode.7 Vdd Vss Vdd Vdd Vdd Vdd Vss Vss is_jal _eq
X18 opcode.0 opcode.1 opcode.2 opcode.3 opcode.4 opcode.5 opcode.6 opcode.7 Vss Vdd Vdd Vdd Vdd Vdd Vss Vss is_ret _eq
X19 opcode.0 opcode.1 opcode.2 opcode.3 opcode.4 opcode.5 opcode.6 opcode.7 Vss Vss Vdd Vdd Vdd Vdd Vss Vss is_jmp _eq
X20 opcode.2 opcode.3 opcode.4 Vss Vss Vss 17 _ge
X21 opcode.2 opcode.3 opcode.4 Vdd Vss Vdd 18 _le
X22 is_branch 13 is_skip _logic_and
X23 17 18 19 _logic_and
X24 is_ldst 19 needs_s2 _logic_and
X25 irq_pending flag_ie 20 _logic_and
X26 21 22 int_request _logic_and
X27 skip_set 22 3 _logic_and
X28 10 skip_flag 4 _logic_and
X29 int_request 23 24 _logic_and
X30 24 25 26 _logic_and
X31 26 27 28 _logic_and
X32 28 29 30 _logic_and
X33 30 31 32 _logic_and
X34 33 34 35 _logic_and
X35 is_branch 36 37 _logic_and
X36 is_ldst 22 38 _logic_and
X37 is_push 22 39 _logic_and
X38 is_pop 22 40 _logic_and
X39 needs_s2 23 _logic_not
X40 is_push 25 _logic_not
X41 is_pop 27 _logic_not
X42 is_jal 29 _logic_not
X43 is_ret 31 _logic_not
X44 is_skip 36 _logic_not
X45 skip_flag 22 _logic_not
X46 nmi_pending 20 21 _logic_or
X47 needs_s2 is_push 41 _logic_or
X48 41 is_pop 42 _logic_or
X49 opcode.2 opcode.3 opcode.4 Vdd Vss Vdd 43 _ne
X50 opcode.0 opcode.1 opcode.2 opcode.3 opcode.4 opcode.5 opcode.6 opcode.7 Vss Vss Vss Vdd Vdd Vss Vss Vss 33 _ne
X51 opcode.0 opcode.1 opcode.2 opcode.3 opcode.4 opcode.5 opcode.6 opcode.7 Vss Vss Vdd Vdd Vdd Vss Vss Vss 34 _ne
X52 flag_n 44 _not
X53 flag_z 45 _not
X54 flag_c 46 _not
X55 rst_n clk next_state.0 next_state.1 next_state.2 state.0 state.1 state.2 _adff
X56 47 Vss is_ptr 48 _mux
X57 49 Vss is_ptr 50 _mux
X58 51 Vss is_ptr 52 _mux
X59 Vss Vdd is_jmp 53 _mux
X60 48 Vss is_jmp 54 _mux
X61 50 Vss is_jmp 55 _mux
X62 52 Vss is_jmp 56 _mux
X63 57 Vss is_jmp 58 _mux
X64 59 Vss is_jmp 60 _mux
X65 Vss Vdd skip_cond 61 _mux
X66 Vss 61 is_skip 62 _mux
X67 54 Vss is_skip 63 _mux
X68 55 Vss is_skip 64 _mux
X69 56 Vss is_skip 65 _mux
X70 58 Vss is_skip 66 _mux
X71 60 Vss is_skip 67 _mux
X72 53 Vss is_skip 68 _mux
X73 Vss Vdd branch_taken 69 _mux
X74 Vss 69 37 70 _mux
X75 62 Vss 37 71 _mux
X76 63 Vss 37 72 _mux
X77 64 Vss 37 73 _mux
X78 65 Vss 37 74 _mux
X79 66 Vss 37 75 _mux
X80 67 Vss 37 76 _mux
X81 68 Vss 37 77 _mux
X82 Vss Vdd is_shift 78 _mux
X83 71 Vss is_shift 79 _mux
X84 72 Vss is_shift 80 _mux
X85 73 Vss is_shift 81 _mux
X86 74 Vss is_shift 82 _mux
X87 75 Vss is_shift 83 _mux
X88 76 Vss is_shift 84 _mux
X89 70 Vss is_shift 85 _mux
X90 77 Vss is_shift 86 _mux
X91 35 Vdd 18 87 _mux
X92 88.0 88.1 88.2 Vdd Vdd Vdd 18 89.0 89.1 89.2 _mux
X93 Vdd Vss 18 90 _mux
X94 78 90 is_imm 91 _mux
X95 Vdd Vdd Vdd 89.0 89.1 89.2 is_imm 92.0 92.1 92.2 _mux
X96 78 87 is_imm 93 _mux
X97 79 Vss is_imm 94 _mux
X98 80 Vss is_imm 95 _mux
X99 81 Vss is_imm 96 _mux
X100 82 Vss is_imm 97 _mux
X101 83 Vss is_imm 98 _mux
X102 84 Vss is_imm 99 _mux
X103 85 Vss is_imm 100 _mux
X104 86 Vss is_imm 101 _mux
X105 91 Vdd is_alu 102 _mux
X106 93 43 is_alu 103 _mux
X107 92.0 92.1 92.2 opcode.2 opcode.3 opcode.4 is_alu 104.0 104.1 104.2 _mux
X108 94 Vss is_alu 105 _mux
X109 95 Vss is_alu 106 _mux
X110 96 Vss is_alu 107 _mux
X111 97 Vss is_alu 108 _mux
X112 98 Vss is_alu 109 _mux
X113 99 Vss is_alu 110 _mux
X114 100 Vss is_alu 111 _mux
X115 101 Vss is_alu 112 _mux
X116 105 Vss skip_flag 113 _mux
X117 106 Vss skip_flag 114 _mux
X118 107 Vss skip_flag 115 _mux
X119 108 Vss skip_flag 116 _mux
X120 109 Vss skip_flag 117 _mux
X121 110 Vss skip_flag 118 _mux
X122 102 Vss skip_flag 119 _mux
X123 111 Vss skip_flag 120 _mux
X124 112 Vss skip_flag 121 _mux
X125 104.0 104.1 104.2 Vdd Vdd Vdd skip_flag 122.0 122.1 122.2 _mux
X126 103 Vss skip_flag 123 _mux
X127 Vss Vdd 12 pc_inc _mux
X128 Vss Vdd 11 ir_load0 _mux
X129 Vss 124 125 Vdd 126 127 12 mem_rd _pmux
X130 Vss Vss Vss 128.0 128.1 128.2 129.0 129.1 129.2 126 127 addr_src.0 addr_src.1 addr_src.2 _pmux
X131 Vss 113 10 skip_set _mux
X132 Vss 114 10 ie_clr _mux
X133 Vss 115 10 ie_set _mux
X134 Vss 116 10 halt_out _mux
X135 Vss Vdd 10 ir_load1 _mux
X136 Vss 130 131 126 127 sp_dec _pmux
X137 Vss 124 132 126 127 sp_inc _pmux
X138 Vss 117 10 ptr_dec _mux
X139 Vss 133 118 127 10 ptr_inc _pmux
X140 Vss 119 10 flags_we _mux
X141 Vss 120 10 pc_branch _mux
X142 Vss 130 121 134 10 pc_load _pmux
X143 state.0 state.1 state.2 Vss Vss Vdd 134 _eq
X144 Vdd Vdd Vdd 122.0 122.1 122.2 10 alu_op.0 alu_op.1 alu_op.2 _mux
X145 Vss 130 135 126 127 mem_wr _pmux
X146 Vss 136 123 127 10 reg_we _pmux
X147 Vss Vss Vss Vss Vss Vdd is_jal 137.0 137.1 137.2 _mux
X148 Vss Vss Vss Vdd Vdd Vss is_ret 138.0 138.1 138.2 _mux
X149 138.0 138.1 138.2 Vdd Vdd Vss is_jal 139.0 139.1 139.2 _mux
X150 128.0 128.1 128.2 Vss Vdd Vss 42 140.0 140.1 140.2 _mux
X151 140.0 140.1 140.2 Vss Vdd Vss 32 141.0 141.1 141.2 _mux
X152 Vss Vss Vss 137.0 137.1 137.2 139.0 139.1 139.2 141.0 141.1 141.2 Vdd Vss Vss 126 127 10 11 next_state.0 next_state.1 next_state.2 _pmux
X153 state.0 state.1 state.2 Vdd Vdd Vss 126 _eq
X154 state.0 state.1 state.2 Vss Vdd Vss 127 _eq
X155 state.0 state.1 state.2 Vdd Vss Vss 10 _eq
X156 state.0 state.1 state.2 11 _logic_not
X157 _NC0 Vss 4 142 _mux
X158 142 Vdd 3 1 _mux
X159 _NC1 Vss Vdd 44 flag_n 46 flag_c 45 flag_z 143 144 145 146 7 8 6 5 branch_taken _pmux
X160 opcode.2 opcode.3 opcode.4 Vdd Vdd Vdd 143 _eq
X161 opcode.2 opcode.3 opcode.4 Vss Vdd Vdd 144 _eq
X162 opcode.2 opcode.3 opcode.4 Vdd Vss Vdd 145 _eq
X163 opcode.2 opcode.3 opcode.4 Vss Vss Vdd 146 _eq
X164 opcode.2 opcode.3 opcode.4 Vdd Vdd Vss 7 _eq
X165 opcode.2 opcode.3 opcode.4 Vss Vdd Vss 8 _eq
X166 opcode.2 opcode.3 opcode.4 Vdd Vss Vss 6 _eq
X167 opcode.2 opcode.3 opcode.4 5 _logic_not
X168 Vss Vdd is_ret 147 _mux
X169 Vss Vss Vss Vss Vdd Vss is_ret 148.0 148.1 148.2 _mux
X170 Vss Vdd is_jal 130 _mux
X171 148.0 148.1 148.2 Vss Vdd Vss is_jal 128.0 128.1 128.2 _mux
X172 147 Vss is_jal 124 _mux
X173 Vss Vdd 40 149 _mux
X174 124 Vdd 40 150 _mux
X175 128.0 128.1 128.2 Vss Vdd Vss 40 151.0 151.1 151.2 _mux
X176 130 Vss 40 152 _mux
X177 152 Vdd 39 153 _mux
X178 151.0 151.1 151.2 Vss Vdd Vss 39 154.0 154.1 154.2 _mux
X179 150 Vss 39 155 _mux
X180 149 Vss 39 156 _mux
X181 Vdd Vss opcode.2 157 _mux
X182 Vss Vdd opcode.2 158 _mux
X183 Vss Vss Vss Vss Vdd Vss Vdd Vss Vss 159 9 160.0 160.1 160.2 _pmux
X184 145 146 159 _reduce_or
X185 Vss Vdd 161 162 _mux
X186 7 8 161 _reduce_or
X187 153 158 38 135 _mux
X188 155 157 38 125 _mux
X189 156 157 38 136 _mux
X190 Vss 162 38 133 _mux
X191 154.0 154.1 154.2 160.0 160.1 160.2 38 129.0 129.1 129.2 _mux
X192 153 Vss 38 131 _mux
X193 155 Vss 38 132 _mux
X194 Vss Vdd 163 164 _mux
X195 opcode.0 opcode.1 opcode.2 opcode.3 opcode.4 opcode.5 opcode.6 opcode.7 Vdd Vdd Vss Vss Vdd Vdd Vdd Vdd 163 _eq
X196 Vss Vdd 165 166 _mux
X197 opcode.0 opcode.1 opcode.2 opcode.3 opcode.4 opcode.5 opcode.6 opcode.7 Vss Vdd Vss Vss Vdd Vdd Vdd Vdd 165 _eq
X198 Vss Vdd 167 168 _mux
X199 opcode.0 opcode.1 opcode.2 opcode.3 opcode.4 opcode.5 opcode.6 opcode.7 Vdd Vdd Vdd Vdd Vdd Vdd Vdd Vdd 167 _eq
X200 Vss 164 is_system 47 _mux
X201 Vss 166 is_system 49 _mux
X202 Vss 168 is_system 51 _mux
X203 Vss Vdd 6 169 _mux
X204 Vss Vdd 5 170 _mux
X205 169 Vss 5 171 _mux
X206 Vss 171 is_ptr 57 _mux
X207 Vss 170 is_ptr 59 _mux
X208 opcode.2 opcode.3 opcode.4 Vss Vdd Vdd 88.0 88.1 88.2 _sub
X209 172 flag_z 14 skip_cond _mux
X210 173 45 15 172 _mux
X211 46 flag_c 16 173 _mux
V0 Vss int_enter DC 0
V1 opcode.2 op.0 DC 0
V2 opcode.3 op.1 DC 0
V3 opcode.4 op.2 DC 0
V4 opcode.0 reg_field.0 DC 0
V5 opcode.1 reg_field.1 DC 0
V6 skip_flag skip_active DC 0
V7 state.0 state_out.0 DC 0
V8 state.1 state_out.1 DC 0
V9 state.2 state_out.2 DC 0
V10 opcode.5 unit.0 DC 0
V11 opcode.6 unit.1 DC 0
V12 opcode.7 unit.2 DC 0
.ENDS rv8_control

.SUBCKT rv8_pc clk rst_n inc load branch load_val.0 load_val.1 load_val.2 load_val.3 load_val.4 load_val.5 load_val.6 load_val.7 load_val.8 load_val.9 load_val.10 load_val.11 load_val.12 load_val.13 load_val.14 load_val.15 offset.0 offset.1 offset.2 offset.3 offset.4 offset.5 offset.6 offset.7 pc.0 pc.1 pc.2 pc.3 pc.4 pc.5 pc.6 pc.7 pc.8 pc.9 pc.10 pc.11 pc.12 pc.13 pc.14 pc.15
X0 pc.0 pc.1 pc.2 pc.3 pc.4 pc.5 pc.6 pc.7 pc.8 pc.9 pc.10 pc.11 pc.12 pc.13 pc.14 pc.15 Vdd Vss Vss Vss Vss Vss Vss Vss Vss Vss Vss Vss Vss Vss Vss Vss 1.0 1.1 1.2 1.3 1.4 1.5 1.6 1.7 1.8 1.9 1.10 1.11 1.12 1.13 1.14 1.15 _add
X1 pc.0 pc.1 pc.2 pc.3 pc.4 pc.5 pc.6 pc.7 pc.8 pc.9 pc.10 pc.11 pc.12 pc.13 pc.14 pc.15 offset.0 offset.1 offset.2 offset.3 offset.4 offset.5 offset.6 offset.7 offset.7 offset.7 offset.7 offset.7 offset.7 offset.7 offset.7 offset.7 branch_target.0 branch_target.1 branch_target.2 branch_target.3 branch_target.4 branch_target.5 branch_target.6 branch_target.7 branch_target.8 branch_target.9 branch_target.10 branch_target.11 branch_target.12 branch_target.13 branch_target.14 branch_target.15 _add
X2 rst_n clk 2.0 2.1 2.2 2.3 2.4 2.5 2.6 2.7 2.8 2.9 2.10 2.11 2.12 2.13 2.14 2.15 3 pc.0 pc.1 pc.2 pc.3 pc.4 pc.5 pc.6 pc.7 pc.8 pc.9 pc.10 pc.11 pc.12 pc.13 pc.14 pc.15 _adffe
X3 inc load branch 3 _reduce_bool
X4 _NC0 _NC1 _NC2 _NC3 _NC4 _NC5 _NC6 _NC7 _NC8 _NC9 _NC10 _NC11 _NC12 _NC13 _NC14 _NC15 1.0 1.1 1.2 1.3 1.4 1.5 1.6 1.7 1.8 1.9 1.10 1.11 1.12 1.13 1.14 1.15 inc 4.0 4.1 4.2 4.3 4.4 4.5 4.6 4.7 4.8 4.9 4.10 4.11 4.12 4.13 4.14 4.15 _mux
X5 4.0 4.1 4.2 4.3 4.4 4.5 4.6 4.7 4.8 4.9 4.10 4.11 4.12 4.13 4.14 4.15 branch_target.0 branch_target.1 branch_target.2 branch_target.3 branch_target.4 branch_target.5 branch_target.6 branch_target.7 branch_target.8 branch_target.9 branch_target.10 branch_target.11 branch_target.12 branch_target.13 branch_target.14 branch_target.15 branch 5.0 5.1 5.2 5.3 5.4 5.5 5.6 5.7 5.8 5.9 5.10 5.11 5.12 5.13 5.14 5.15 _mux
X6 5.0 5.1 5.2 5.3 5.4 5.5 5.6 5.7 5.8 5.9 5.10 5.11 5.12 5.13 5.14 5.15 load_val.0 load_val.1 load_val.2 load_val.3 load_val.4 load_val.5 load_val.6 load_val.7 load_val.8 load_val.9 load_val.10 load_val.11 load_val.12 load_val.13 load_val.14 load_val.15 load 2.0 2.1 2.2 2.3 2.4 2.5 2.6 2.7 2.8 2.9 2.10 2.11 2.12 2.13 2.14 2.15 _mux
.ENDS rv8_pc

.SUBCKT rv8_pointer clk rst_n load_pl load_ph inc16 dec16 data_in.0 data_in.1 data_in.2 data_in.3 data_in.4 data_in.5 data_in.6 data_in.7 ptr_out.0 ptr_out.1 ptr_out.2 ptr_out.3 ptr_out.4 ptr_out.5 ptr_out.6 ptr_out.7 ptr_out.8 ptr_out.9 ptr_out.10 ptr_out.11 ptr_out.12 ptr_out.13 ptr_out.14 ptr_out.15 pl_out.0 pl_out.1 pl_out.2 pl_out.3 pl_out.4 pl_out.5 pl_out.6 pl_out.7 ph_out.0 ph_out.1 ph_out.2 ph_out.3 ph_out.4 ph_out.5 ph_out.6 ph_out.7
X0 pl.0 pl.1 pl.2 pl.3 pl.4 pl.5 pl.6 pl.7 ph.0 ph.1 ph.2 ph.3 ph.4 ph.5 ph.6 ph.7 Vdd Vss Vss Vss Vss Vss Vss Vss Vss Vss Vss Vss Vss Vss Vss Vss 1.0 1.1 1.2 1.3 1.4 1.5 1.6 1.7 1.8 1.9 1.10 1.11 1.12 1.13 1.14 1.15 _add
X1 rst_n clk 2.0 2.1 2.2 2.3 2.4 2.5 2.6 2.7 3 pl.0 pl.1 pl.2 pl.3 pl.4 pl.5 pl.6 pl.7 _adffe
X2 rst_n clk 4.0 4.1 4.2 4.3 4.4 4.5 4.6 4.7 5 ph.0 ph.1 ph.2 ph.3 ph.4 ph.5 ph.6 ph.7 _adffe
X3 load_pl load_ph inc16 dec16 6 _reduce_bool
X4 load_pl load_ph Vss Vdd 7 _ne
X5 load_ph inc16 dec16 8 _reduce_bool
X6 load_pl 9 _not
X7 7 6 3 _reduce_and
X8 8 9 5 _reduce_and
X9 _NC0 _NC1 _NC2 _NC3 _NC4 _NC5 _NC6 _NC7 10.8 10.9 10.10 10.11 10.12 10.13 10.14 10.15 dec16 11.0 11.1 11.2 11.3 11.4 11.5 11.6 11.7 _mux
X10 11.0 11.1 11.2 11.3 11.4 11.5 11.6 11.7 1.8 1.9 1.10 1.11 1.12 1.13 1.14 1.15 inc16 12.0 12.1 12.2 12.3 12.4 12.5 12.6 12.7 _mux
X11 12.0 12.1 12.2 12.3 12.4 12.5 12.6 12.7 data_in.0 data_in.1 data_in.2 data_in.3 data_in.4 data_in.5 data_in.6 data_in.7 load_ph 4.0 4.1 4.2 4.3 4.4 4.5 4.6 4.7 _mux
X12 _NC8 _NC9 _NC10 _NC11 _NC12 _NC13 _NC14 _NC15 10.0 10.1 10.2 10.3 10.4 10.5 10.6 10.7 dec16 13.0 13.1 13.2 13.3 13.4 13.5 13.6 13.7 _mux
X13 13.0 13.1 13.2 13.3 13.4 13.5 13.6 13.7 1.0 1.1 1.2 1.3 1.4 1.5 1.6 1.7 inc16 14.0 14.1 14.2 14.3 14.4 14.5 14.6 14.7 _mux
X14 14.0 14.1 14.2 14.3 14.4 14.5 14.6 14.7 _NC16 _NC17 _NC18 _NC19 _NC20 _NC21 _NC22 _NC23 load_ph 15.0 15.1 15.2 15.3 15.4 15.5 15.6 15.7 _mux
X15 15.0 15.1 15.2 15.3 15.4 15.5 15.6 15.7 data_in.0 data_in.1 data_in.2 data_in.3 data_in.4 data_in.5 data_in.6 data_in.7 load_pl 2.0 2.1 2.2 2.3 2.4 2.5 2.6 2.7 _mux
X16 pl.0 pl.1 pl.2 pl.3 pl.4 pl.5 pl.6 pl.7 ph.0 ph.1 ph.2 ph.3 ph.4 ph.5 ph.6 ph.7 Vdd Vss Vss Vss Vss Vss Vss Vss Vss Vss Vss Vss Vss Vss Vss Vss 10.0 10.1 10.2 10.3 10.4 10.5 10.6 10.7 10.8 10.9 10.10 10.11 10.12 10.13 10.14 10.15 _sub
V0 ph.0 ph_out.0 DC 0
V1 ph.1 ph_out.1 DC 0
V2 ph.2 ph_out.2 DC 0
V3 ph.3 ph_out.3 DC 0
V4 ph.4 ph_out.4 DC 0
V5 ph.5 ph_out.5 DC 0
V6 ph.6 ph_out.6 DC 0
V7 ph.7 ph_out.7 DC 0
V8 pl.0 pl_out.0 DC 0
V9 pl.1 pl_out.1 DC 0
V10 pl.2 pl_out.2 DC 0
V11 pl.3 pl_out.3 DC 0
V12 pl.4 pl_out.4 DC 0
V13 pl.5 pl_out.5 DC 0
V14 pl.6 pl_out.6 DC 0
V15 pl.7 pl_out.7 DC 0
V16 pl.0 ptr_out.0 DC 0
V17 pl.1 ptr_out.1 DC 0
V18 pl.2 ptr_out.2 DC 0
V19 pl.3 ptr_out.3 DC 0
V20 pl.4 ptr_out.4 DC 0
V21 pl.5 ptr_out.5 DC 0
V22 pl.6 ptr_out.6 DC 0
V23 pl.7 ptr_out.7 DC 0
V24 ph.0 ptr_out.8 DC 0
V25 ph.1 ptr_out.9 DC 0
V26 ph.2 ptr_out.10 DC 0
V27 ph.3 ptr_out.11 DC 0
V28 ph.4 ptr_out.12 DC 0
V29 ph.5 ptr_out.13 DC 0
V30 ph.6 ptr_out.14 DC 0
V31 ph.7 ptr_out.15 DC 0
.ENDS rv8_pointer

.SUBCKT rv8_regfile clk rst_n we wr_sel.0 wr_sel.1 wr_sel.2 rd_sel.0 rd_sel.1 rd_sel.2 wr_data.0 wr_data.1 wr_data.2 wr_data.3 wr_data.4 wr_data.5 wr_data.6 wr_data.7 rd_data.0 rd_data.1 rd_data.2 rd_data.3 rd_data.4 rd_data.5 rd_data.6 rd_data.7 a0_out.0 a0_out.1 a0_out.2 a0_out.3 a0_out.4 a0_out.5 a0_out.6 a0_out.7 sp_out.0 sp_out.1 sp_out.2 sp_out.3 sp_out.4 sp_out.5 sp_out.6 sp_out.7 pg_out.0 pg_out.1 pg_out.2 pg_out.3 pg_out.4 pg_out.5 pg_out.6 pg_out.7 const_sel.0 const_sel.1
X0 rst_n clk wr_data.0 wr_data.1 wr_data.2 wr_data.3 wr_data.4 wr_data.5 wr_data.6 wr_data.7 1 regs_2_.0 regs_2_.1 regs_2_.2 regs_2_.3 regs_2_.4 regs_2_.5 regs_2_.6 regs_2_.7 _adffe
X1 rst_n clk wr_data.0 wr_data.1 wr_data.2 wr_data.3 wr_data.4 wr_data.5 wr_data.6 wr_data.7 2 regs_3_.0 regs_3_.1 regs_3_.2 regs_3_.3 regs_3_.4 regs_3_.5 regs_3_.6 regs_3_.7 _adffe
X2 rst_n clk wr_data.0 wr_data.1 wr_data.2 wr_data.3 wr_data.4 wr_data.5 wr_data.6 wr_data.7 3 regs_4_.0 regs_4_.1 regs_4_.2 regs_4_.3 regs_4_.4 regs_4_.5 regs_4_.6 regs_4_.7 _adffe
X3 rst_n clk wr_data.0 wr_data.1 wr_data.2 wr_data.3 wr_data.4 wr_data.5 wr_data.6 wr_data.7 4 regs_5_.0 regs_5_.1 regs_5_.2 regs_5_.3 regs_5_.4 regs_5_.5 regs_5_.6 regs_5_.7 _adffe
X4 rst_n clk wr_data.0 wr_data.1 wr_data.2 wr_data.3 wr_data.4 wr_data.5 wr_data.6 wr_data.7 5 regs_6_.0 regs_6_.1 regs_6_.2 regs_6_.3 regs_6_.4 regs_6_.5 regs_6_.6 regs_6_.7 _adffe
X5 rst_n clk wr_data.0 wr_data.1 wr_data.2 wr_data.3 wr_data.4 wr_data.5 wr_data.6 wr_data.7 6 regs_1_.0 regs_1_.1 regs_1_.2 regs_1_.3 regs_1_.4 regs_1_.5 regs_1_.6 regs_1_.7 _adffe
X6 7 8 1 _reduce_and
X7 7 9 2 _reduce_and
X8 7 10 3 _reduce_and
X9 7 11 4 _reduce_and
X10 7 12 5 _reduce_and
X11 7 13 6 _reduce_and
X12 we 14 7 _logic_and
X13 wr_sel.0 wr_sel.1 wr_sel.2 14 _reduce_bool
X14 wr_sel.0 wr_sel.1 wr_sel.2 Vss Vdd Vdd 12 _eq
X15 wr_sel.0 wr_sel.1 wr_sel.2 Vdd Vss Vdd 11 _eq
X16 wr_sel.0 wr_sel.1 wr_sel.2 Vss Vss Vdd 10 _eq
X17 wr_sel.0 wr_sel.1 wr_sel.2 Vdd Vdd Vss 9 _eq
X18 wr_sel.0 wr_sel.1 wr_sel.2 Vss Vdd Vss 8 _eq
X19 wr_sel.0 wr_sel.1 wr_sel.2 Vdd Vss Vss 13 _eq
X20 _NC0 _NC1 _NC2 _NC3 _NC4 _NC5 _NC6 _NC7 regs_6_.0 regs_6_.1 regs_6_.2 regs_6_.3 regs_6_.4 regs_6_.5 regs_6_.6 regs_6_.7 regs_5_.0 regs_5_.1 regs_5_.2 regs_5_.3 regs_5_.4 regs_5_.5 regs_5_.6 regs_5_.7 regs_4_.0 regs_4_.1 regs_4_.2 regs_4_.3 regs_4_.4 regs_4_.5 regs_4_.6 regs_4_.7 regs_3_.0 regs_3_.1 regs_3_.2 regs_3_.3 regs_3_.4 regs_3_.5 regs_3_.6 regs_3_.7 regs_2_.0 regs_2_.1 regs_2_.2 regs_2_.3 regs_2_.4 regs_2_.5 regs_2_.6 regs_2_.7 regs_1_.0 regs_1_.1 regs_1_.2 regs_1_.3 regs_1_.4 regs_1_.5 regs_1_.6 regs_1_.7 15 16 17 18 19 20 21.0 21.1 21.2 21.3 21.4 21.5 21.6 21.7 _pmux
X21 rd_sel.0 rd_sel.1 rd_sel.2 Vss Vdd Vdd 15 _eq
X22 rd_sel.0 rd_sel.1 rd_sel.2 Vdd Vss Vdd 16 _eq
X23 rd_sel.0 rd_sel.1 rd_sel.2 Vss Vss Vdd 17 _eq
X24 rd_sel.0 rd_sel.1 rd_sel.2 Vdd Vdd Vss 18 _eq
X25 rd_sel.0 rd_sel.1 rd_sel.2 Vss Vdd Vss 19 _eq
X26 rd_sel.0 rd_sel.1 rd_sel.2 Vdd Vss Vss 20 _eq
X27 rd_sel.0 rd_sel.1 rd_sel.2 22 _logic_not
X28 _NC8 _NC9 _NC10 _NC11 _NC12 _NC13 _NC14 _NC15 Vss Vss Vss Vss Vss Vss Vss Vdd Vdd Vdd Vdd Vdd Vdd Vdd Vdd Vdd Vdd Vss Vss Vss Vss Vss Vss Vss Vss Vss Vss Vss Vss Vss Vss Vss 23 24 25 26 27.0 27.1 27.2 27.3 27.4 27.5 27.6 27.7 _pmux
X29 const_sel.0 const_sel.1 Vdd Vdd 23 _eq
X30 const_sel.0 const_sel.1 Vss Vdd 24 _eq
X31 const_sel.0 const_sel.1 Vdd Vss 25 _eq
X32 const_sel.0 const_sel.1 26 _logic_not
X33 21.0 21.1 21.2 21.3 21.4 21.5 21.6 21.7 27.0 27.1 27.2 27.3 27.4 27.5 27.6 27.7 22 rd_data.0 rd_data.1 rd_data.2 rd_data.3 rd_data.4 rd_data.5 rd_data.6 rd_data.7 _mux
V0 regs_2_.0 a0_out.0 DC 0
V1 regs_2_.1 a0_out.1 DC 0
V2 regs_2_.2 a0_out.2 DC 0
V3 regs_2_.3 a0_out.3 DC 0
V4 regs_2_.4 a0_out.4 DC 0
V5 regs_2_.5 a0_out.5 DC 0
V6 regs_2_.6 a0_out.6 DC 0
V7 regs_2_.7 a0_out.7 DC 0
V8 Vdd i.0 DC 0
V9 Vdd i.1 DC 0
V10 Vdd i.2 DC 0
V11 Vss i.3 DC 0
V12 Vss i.4 DC 0
V13 Vss i.5 DC 0
V14 Vss i.6 DC 0
V15 Vss i.7 DC 0
V16 Vss i.8 DC 0
V17 Vss i.9 DC 0
V18 Vss i.10 DC 0
V19 Vss i.11 DC 0
V20 Vss i.12 DC 0
V21 Vss i.13 DC 0
V22 Vss i.14 DC 0
V23 Vss i.15 DC 0
V24 Vss i.16 DC 0
V25 Vss i.17 DC 0
V26 Vss i.18 DC 0
V27 Vss i.19 DC 0
V28 Vss i.20 DC 0
V29 Vss i.21 DC 0
V30 Vss i.22 DC 0
V31 Vss i.23 DC 0
V32 Vss i.24 DC 0
V33 Vss i.25 DC 0
V34 Vss i.26 DC 0
V35 Vss i.27 DC 0
V36 Vss i.28 DC 0
V37 Vss i.29 DC 0
V38 Vss i.30 DC 0
V39 Vss i.31 DC 0
V40 regs_6_.0 pg_out.0 DC 0
V41 regs_6_.1 pg_out.1 DC 0
V42 regs_6_.2 pg_out.2 DC 0
V43 regs_6_.3 pg_out.3 DC 0
V44 regs_6_.4 pg_out.4 DC 0
V45 regs_6_.5 pg_out.5 DC 0
V46 regs_6_.6 pg_out.6 DC 0
V47 regs_6_.7 pg_out.7 DC 0
V48 regs_1_.0 sp_out.0 DC 0
V49 regs_1_.1 sp_out.1 DC 0
V50 regs_1_.2 sp_out.2 DC 0
V51 regs_1_.3 sp_out.3 DC 0
V52 regs_1_.4 sp_out.4 DC 0
V53 regs_1_.5 sp_out.5 DC 0
V54 regs_1_.6 sp_out.6 DC 0
V55 regs_1_.7 sp_out.7 DC 0
.ENDS rv8_regfile

X0 rst_n clk data_bus.0 data_bus.1 data_bus.2 data_bus.3 data_bus.4 data_bus.5 data_bus.6 data_bus.7 ir_load0 ir_opcode.0 ir_opcode.1 ir_opcode.2 ir_opcode.3 ir_opcode.4 ir_opcode.5 ir_opcode.6 ir_opcode.7 _adffe
X1 rst_n clk data_bus.0 data_bus.1 data_bus.2 data_bus.3 data_bus.4 data_bus.5 data_bus.6 data_bus.7 ir_load1 ir_operand.0 ir_operand.1 ir_operand.2 ir_operand.3 ir_operand.4 ir_operand.5 ir_operand.6 ir_operand.7 _adffe
X2 rst_n clk 1 2 nmi_pending _adffe
X3 rst_n clk alu_zero flags_we flag_z _adffe
X4 rst_n clk 3 4 flag_c _adffe
X5 rst_n clk alu_neg flags_we flag_n _adffe
X6 rst_n clk 5 6 flag_ie _adffe
X7 int_enter 7 2 _reduce_bool
X8 flags_we 8 9 4 _reduce_bool
X9 ie_set ie_clr 6 _reduce_bool
X10 state.0 state.1 state.2 sync _logic_not
X11 ir_opcode.0 ir_opcode.1 ir_opcode.2 ir_opcode.3 ir_opcode.4 ir_opcode.5 ir_opcode.6 ir_opcode.7 Vss Vss Vss Vss Vdd Vdd Vdd Vdd 8 _eq
X12 ir_opcode.0 ir_opcode.1 ir_opcode.2 ir_opcode.3 ir_opcode.4 ir_opcode.5 ir_opcode.6 ir_opcode.7 Vdd Vss Vss Vss Vdd Vdd Vdd Vdd 9 _eq
X13 ir_opcode.0 ir_opcode.1 ir_opcode.2 Vdd Vdd Vss 10 _eq
X14 ir_opcode.0 ir_opcode.1 ir_opcode.2 Vss Vss Vdd 11 _eq
X15 nmi_prev 12 7 _logic_and
X16 reg_we 10 13 _logic_and
X17 reg_we 11 14 _logic_and
X18 nmi_n 12 _logic_not
X19 mem_rd mem_rd_n _not
X20 data_oe mem_wr_n _not
X21 irq_n 15 _not
X22 rst_n clk nmi_n nmi_prev _adff
X23 _NC0 Vdd 7 16 _mux
X24 16 Vss int_enter 1 _mux
X25 _NC1 Vdd ie_set 17 _mux
X26 17 Vss ie_clr 5 _mux
X27 _NC2 alu_cout flags_we 18 _mux
X28 18 Vss 8 19 _mux
X29 19 Vdd 9 3 _mux
X30 pc_out.0 pc_out.1 pc_out.2 pc_out.3 pc_out.4 pc_out.5 pc_out.6 pc_out.7 pc_out.8 pc_out.9 pc_out.10 pc_out.11 pc_out.12 pc_out.13 pc_out.14 pc_out.15 ir_operand.0 ir_operand.1 ir_operand.2 ir_operand.3 ir_operand.4 ir_operand.5 ir_operand.6 ir_operand.7 Vdd Vdd Vdd Vdd Vdd Vdd Vdd Vdd ir_operand.0 ir_operand.1 ir_operand.2 ir_operand.3 ir_operand.4 ir_operand.5 ir_operand.6 ir_operand.7 pg_out.0 pg_out.1 pg_out.2 pg_out.3 pg_out.4 pg_out.5 pg_out.6 pg_out.7 ir_operand.0 ir_operand.1 ir_operand.2 ir_operand.3 ir_operand.4 ir_operand.5 ir_operand.6 ir_operand.7 Vss Vss Vss Vss Vss Vss Vss Vss sp_out.0 sp_out.1 sp_out.2 sp_out.3 sp_out.4 sp_out.5 sp_out.6 sp_out.7 Vss Vss Vss Vss Vdd Vdd Vss Vss ptr_out.0 ptr_out.1 ptr_out.2 ptr_out.3 ptr_out.4 ptr_out.5 ptr_out.6 ptr_out.7 ptr_out.8 ptr_out.9 ptr_out.10 ptr_out.11 ptr_out.12 ptr_out.13 ptr_out.14 ptr_out.15 20 21 22 23 24 addr_bus.0 addr_bus.1 addr_bus.2 addr_bus.3 addr_bus.4 addr_bus.5 addr_bus.6 addr_bus.7 addr_bus.8 addr_bus.9 addr_bus.10 addr_bus.11 addr_bus.12 addr_bus.13 addr_bus.14 addr_bus.15 _pmux
X31 addr_src.0 addr_src.1 addr_src.2 Vdd Vss Vdd 20 _eq
X32 addr_src.0 addr_src.1 addr_src.2 Vss Vss Vdd 21 _eq
X33 addr_src.0 addr_src.1 addr_src.2 Vdd Vdd Vss 22 _eq
X34 addr_src.0 addr_src.1 addr_src.2 Vss Vdd Vss 23 _eq
X35 addr_src.0 addr_src.1 addr_src.2 Vdd Vss Vss 24 _eq
X36 _NC3 _NC4 _NC5 _NC6 _NC7 _NC8 _NC9 _NC10 a0_out.0 a0_out.1 a0_out.2 a0_out.3 a0_out.4 a0_out.5 a0_out.6 a0_out.7 data_oe data_bus.0 data_bus.1 data_bus.2 data_bus.3 data_bus.4 data_bus.5 data_bus.6 data_bus.7 _mux
X37 a0_out.0 a0_out.1 a0_out.2 a0_out.3 a0_out.4 a0_out.5 a0_out.6 a0_out.7 alu_b.0 alu_b.1 alu_b.2 alu_b.3 alu_b.4 alu_b.5 alu_b.6 alu_b.7 alu_op.0 alu_op.1 alu_op.2 flag_c alu_result.0 alu_result.1 alu_result.2 alu_result.3 alu_result.4 alu_result.5 alu_result.6 alu_result.7 alu_cout alu_zero alu_neg rv8_alu
X38 clk rst_n ir_opcode.0 ir_opcode.1 ir_opcode.2 ir_opcode.3 ir_opcode.4 ir_opcode.5 ir_opcode.6 ir_opcode.7 ir_operand.0 ir_operand.1 ir_operand.2 ir_operand.3 ir_operand.4 ir_operand.5 ir_operand.6 ir_operand.7 flag_z flag_c flag_n flag_ie nmi_pending 15 reg_we mem_rd data_oe alu_op.0 alu_op.1 alu_op.2 addr_src.0 addr_src.1 addr_src.2 pc_inc pc_load pc_branch flags_we ptr_inc ptr_dec sp_inc sp_dec ir_load0 ir_load1 halt_out ie_set ie_clr skip_set int_enter state.0 state.1 state.2 rv8_control
X39 clk rst_n pc_inc pc_load pc_branch ptr_out.0 ptr_out.1 ptr_out.2 ptr_out.3 ptr_out.4 ptr_out.5 ptr_out.6 ptr_out.7 ptr_out.8 ptr_out.9 ptr_out.10 ptr_out.11 ptr_out.12 ptr_out.13 ptr_out.14 ptr_out.15 ir_operand.0 ir_operand.1 ir_operand.2 ir_operand.3 ir_operand.4 ir_operand.5 ir_operand.6 ir_operand.7 pc_out.0 pc_out.1 pc_out.2 pc_out.3 pc_out.4 pc_out.5 pc_out.6 pc_out.7 pc_out.8 pc_out.9 pc_out.10 pc_out.11 pc_out.12 pc_out.13 pc_out.14 pc_out.15 rv8_pc
X40 clk rst_n 13 14 ptr_inc ptr_dec alu_result.0 alu_result.1 alu_result.2 alu_result.3 alu_result.4 alu_result.5 alu_result.6 alu_result.7 ptr_out.0 ptr_out.1 ptr_out.2 ptr_out.3 ptr_out.4 ptr_out.5 ptr_out.6 ptr_out.7 ptr_out.8 ptr_out.9 ptr_out.10 ptr_out.11 ptr_out.12 ptr_out.13 ptr_out.14 ptr_out.15 pl_out.0 pl_out.1 pl_out.2 pl_out.3 pl_out.4 pl_out.5 pl_out.6 pl_out.7 ph_out.0 ph_out.1 ph_out.2 ph_out.3 ph_out.4 ph_out.5 ph_out.6 ph_out.7 rv8_pointer
X41 clk rst_n reg_we Vss Vdd Vss ir_operand.0 ir_operand.1 ir_operand.2 alu_result.0 alu_result.1 alu_result.2 alu_result.3 alu_result.4 alu_result.5 alu_result.6 alu_result.7 alu_b.0 alu_b.1 alu_b.2 alu_b.3 alu_b.4 alu_b.5 alu_b.6 alu_b.7 a0_out.0 a0_out.1 a0_out.2 a0_out.3 a0_out.4 a0_out.5 a0_out.6 a0_out.7 sp_out.0 sp_out.1 sp_out.2 sp_out.3 sp_out.4 sp_out.5 sp_out.6 sp_out.7 pg_out.0 pg_out.1 pg_out.2 pg_out.3 pg_out.4 pg_out.5 pg_out.6 pg_out.7 ir_operand.2 ir_operand.3 rv8_regfile
V0 addr_bus.0 addr_mux.0 DC 0
V1 addr_bus.1 addr_mux.1 DC 0
V2 addr_bus.2 addr_mux.2 DC 0
V3 addr_bus.3 addr_mux.3 DC 0
V4 addr_bus.4 addr_mux.4 DC 0
V5 addr_bus.5 addr_mux.5 DC 0
V6 addr_bus.6 addr_mux.6 DC 0
V7 addr_bus.7 addr_mux.7 DC 0
V8 addr_bus.8 addr_mux.8 DC 0
V9 addr_bus.9 addr_mux.9 DC 0
V10 addr_bus.10 addr_mux.10 DC 0
V11 addr_bus.11 addr_mux.11 DC 0
V12 addr_bus.12 addr_mux.12 DC 0
V13 addr_bus.13 addr_mux.13 DC 0
V14 addr_bus.14 addr_mux.14 DC 0
V15 addr_bus.15 addr_mux.15 DC 0
V16 a0_out.0 alu_a.0 DC 0
V17 a0_out.1 alu_a.1 DC 0
V18 a0_out.2 alu_a.2 DC 0
V19 a0_out.3 alu_a.3 DC 0
V20 a0_out.4 alu_a.4 DC 0
V21 a0_out.5 alu_a.5 DC 0
V22 a0_out.6 alu_a.6 DC 0
V23 a0_out.7 alu_a.7 DC 0
V24 data_bus.0 data_in.0 DC 0
V25 data_bus.1 data_in.1 DC 0
V26 data_bus.2 data_in.2 DC 0
V27 data_bus.3 data_in.3 DC 0
V28 data_bus.4 data_in.4 DC 0
V29 data_bus.5 data_in.5 DC 0
V30 data_bus.6 data_in.6 DC 0
V31 data_bus.7 data_in.7 DC 0
V32 a0_out.0 data_out.0 DC 0
V33 a0_out.1 data_out.1 DC 0
V34 a0_out.2 data_out.2 DC 0
V35 a0_out.3 data_out.3 DC 0
V36 a0_out.4 data_out.4 DC 0
V37 a0_out.5 data_out.5 DC 0
V38 a0_out.6 data_out.6 DC 0
V39 a0_out.7 data_out.7 DC 0
V40 halt_out halt DC 0
V41 data_oe mem_wr DC 0
V42 alu_b.0 reg_rd_data.0 DC 0
V43 alu_b.1 reg_rd_data.1 DC 0
V44 alu_b.2 reg_rd_data.2 DC 0
V45 alu_b.3 reg_rd_data.3 DC 0
V46 alu_b.4 reg_rd_data.4 DC 0
V47 alu_b.5 reg_rd_data.5 DC 0
V48 alu_b.6 reg_rd_data.6 DC 0
V49 alu_b.7 reg_rd_data.7 DC 0

************************
* end of SPICE netlist *
************************
